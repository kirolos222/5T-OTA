ADE simulation setup
Run mode: Single Run, Sweeps and Corners
Tests:
  OTA_5:OTA_5:1: OTA_5/OTA_5/schematic, simulator spectre
Global variables:
  Lin = 100n:100n:2u (off)
