ADE simulation setup
Run mode: Single Run, Sweeps and Corners
Tests:
  OTA_5:testing_CM:1: OTA_5/testing_CM/schematic, simulator spectre
    Outputs: waveVsWave(?x (getData("M0:gm" ?result "dc") / getData("M0:id" ?result "dc")) ?y (getData("M0:gm" ?result "dc") / getData("M0:gds" ?result "dc"))); waveVsWave(?x (getData("M0:gm" ?result "dc") / (- getData("M0:id" ?result "dc"))) ?y (getData("M0:gm" ?result "dc") / getData("M0:gds" ?result "dc"))); waveVsWave(?x v("M0:vgs" ?result "dc") ?y (getData("M0:gm" ?result "dc") / getData("M0:id" ?result "dc"))); waveVsWave(?x v("M0:vgs" ?result "dc") ?y (getData("M0:gm" ?result "dc") / (- getData("M0:id" ?result "dc")))); waveVsWave(?x (- v("M0:vgs" ?result "dc")) ?y (getData("M0:gm" ?result "dc") / (- getData("M0:id" ?result "dc")))); waveVsWave(?x (v("M0:vgs" ?result "dc")) ?y (getData("M0:gm" ?result "dc") / (- getData("M0:id" ?result "dc"))))
Global variables:
  LP = 2u
  VGS = 0 (off)
