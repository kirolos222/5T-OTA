ADE simulation setup
Run mode: Single Run, Sweeps and Corners
Tests:
  OTA_5:OTA_layout_TEST:1: OTA_5/OTA_layout_TEST/schematic, simulator spectre
