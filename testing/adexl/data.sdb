ADE simulation setup
Run mode: Single Run, Sweeps and Corners
Tests:
  OTA_5:testing:1: OTA_5/testing/schematic, simulator spectre
    Outputs: gm/gds; gm/id; (getData("M0:id" ?result "dc") / 1e-06); waveVsWave(?x (getData("M0:gm" ?result "dc") / getData("M0:id" ?result "dc")) ?y (getData("M0:vgs" ?result "dc"))); waveVsWave(?x (getData("M0:gm" ?result "dc") / getData("M0:id" ?result "dc")) ?y (v("M0:vgs" ?result "dc"))); waveVsWave(?x v("M0:vds" ?result "dc") ?y (getData("M0:gm" ?result "dc") / getData("M0:id" ?result "dc"))); waveVsWave(?x v("M0:vdsat" ?result "dc") ?y (getData("M0:gm" ?result "dc") / getData("M0:id" ?result "dc")))
Global variables:
  Lin = 3.8u
  Win = 1u
  VinDIFF = 100m:50m:1.2 (off)
